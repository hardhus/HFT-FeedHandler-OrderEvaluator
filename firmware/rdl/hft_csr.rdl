// HFT CSR map: the single source of the host register interface (SystemRDL 2.0).
// Generated from this file (just gen, checked by just gen-check), never edited by hand:
//   firmware/rtl/core/gen/hft_csr.sv, hft_csr_pkg.sv  (PeakRDL-regblock, AXI4-Lite)
//   software/include/gen/hft_csr.h                    (PeakRDL-cheader)
//   firmware/rdl/hft_csr.md                           (PeakRDL-markdown)
// Blocks are regfiles (a nested addrmap would be an external block in regblock).
// Only blocks with a user in RTL are defined; the other ranges of the 64 KiB window are
// reserved for their phases and answer SLVERR.

addrmap hft_csr {
    name = "HFT FeedHandler CSR";
    desc = "Host register map. 32-bit registers, 64 KiB window, SLVERR on unmapped addresses and illegal accesses.";
    default regwidth = 32;
    default accesswidth = 32;

    regfile {
        name = "Global";
        desc = "Identification and a scratch register.";

        reg {
            name = "Identification";
            field {
                desc = "Constant \"HFT1\" (0x48465431): the right device is mapped.";
                sw = r; hw = na;
            } id[31:0] = 32'h4846_5431;
        } ID @ 0x0;

        reg {
            name = "Register map version";
            field {
                desc = "Major.minor of this map: 0x0005_0001 is the F5 map with the F3 FEED block. A minor step only adds registers (software for an older minor still works); a major step changes existing ones. Software checks it before use.";
                sw = r; hw = na;
            } version[31:0] = 32'h0005_0001;
        } VERSION @ 0x4;

        reg {
            name = "Scratch";
            field {
                desc = "Read/write, no hardware effect: bus read-back test.";
                sw = rw; hw = na;
            } value[31:0] = 32'h0;
        } SCRATCH @ 0x8;
    } GLOBAL @ 0x0000;

    regfile {
        name = "Network receive";
        desc = "eth_ip_udp_rx configuration. Every register here is a shadow: a write changes nothing in the receiver until NET_COMMIT, which moves the whole block to the net clock domain in one transfer; the receiver then switches to it in a single cycle. Reads return the shadow (what was written); NET_STATUS.commit_busy tells whether the last commit has been applied.";

        reg {
            name = "Receive control";
            field {
                desc = "Receiver enabled. 0 after reset: frames are dropped (reason DISABLED) until software has written a complete configuration and committed it with rx_en = 1.";
                sw = rw; hw = r;
            } rx_en[0:0] = 1'b0;
            field {
                desc = "Accept frames to the broadcast MAC ff:ff:ff:ff:ff:ff.";
                sw = rw; hw = r;
            } accept_bcast[1:1] = 1'b0;
        } NET_CTRL @ 0x00;

        reg {
            name = "Local MAC, low";
            field {
                desc = "MAC address bits [31:0]: the last four bytes (02:00:00:00:00:01 -> 0x00000001).";
                sw = rw; hw = r;
            } mac[31:0] = 32'h0;
        } LOCAL_MAC_LO @ 0x04;

        reg {
            name = "Local MAC, high";
            field {
                desc = "MAC address bits [47:32]: the first two bytes (02:00:00:00:00:01 -> 0x0200).";
                sw = rw; hw = r;
            } mac[15:0] = 16'h0;
        } LOCAL_MAC_HI @ 0x08;

        reg {
            name = "Commit";
            field {
                desc = "Write 1: send the whole NET block to the receiver (atomic). A commit while the previous one is in flight is not lost: the newest shadow is sent when the transfer is free.";
                sw = w; hw = r; singlepulse;
            } commit[0:0] = 1'b0;
        } NET_COMMIT @ 0x0C;

        reg {
            name = "Status";
            field {
                desc = "1 while a commit is pending or in flight. 0: every write before the last NET_COMMIT is in effect in the receiver.";
                sw = r; hw = w;
            } commit_busy[0:0];
        } NET_STATUS @ 0x10;

        regfile {
            name = "Destination filter";
            desc = "A frame passes when its destination IP and UDP port equal an enabled entry. The lowest matching index is reported with the payload.";
            reg {
                name = "Filter IP";
                field {
                    desc = "Destination IPv4 address (10.0.0.2 -> 0x0A000002), unicast or multicast group.";
                    sw = rw; hw = r;
                } ip[31:0] = 32'h0;
            } IP @ 0x0;
            reg {
                name = "Filter port and enable";
                field {
                    desc = "Destination UDP port.";
                    sw = rw; hw = r;
                } port[15:0] = 16'h0;
                field {
                    desc = "Entry enabled.";
                    sw = rw; hw = r;
                } en[16:16] = 1'b0;
            } PORT_EN @ 0x4;
        } FILTER[8] @ 0x20 += 0x8;
    } NET @ 0x0100;

    // 64-bit counter read as two words. Values change only when a snapshot lands, so LO and
    // HI of one snapshot always belong together.
    regfile counter64 {
        name = "64-bit counter";
        reg {
            name = "Low word";
            field {
                desc = "Counter bits [31:0] at the last snapshot.";
                sw = r; hw = w;
            } value[31:0];
        } LO @ 0x0;
        reg {
            name = "High word";
            field {
                desc = "Counter bits [63:32] at the last snapshot.";
                sw = r; hw = w;
            } value[31:0];
        } HI @ 0x4;
    };

    regfile {
        name = "MoldUDP64 feed";
        desc = "moldudp64_rx configuration, resync and counters. FEED_CTRL, SESSION_* and RESYNC_SEQ_* are a shadow like the NET block: FEED_COMMIT moves them to the net clock domain in one transfer. EXPECTED_SEQ, FEED_STATE and the MOLD_* counters (net clock domain, 64 bit, wrap; cleared only by reset) are updated by STATS_CTRL.snapshot in the same net clock cycle as the STATS counters; STATS_SEQ counts both. MOLD_<status> is at 0x0240 + 8 * status, status = mold_status_e in hft_pkg.sv.";

        reg {
            name = "Feed control";
            field {
                desc = "Feed enabled. 0 after reset: every packet is counted as DISABLED until software has committed a configuration with enable = 1.";
                sw = rw; hw = r;
            } enable[0:0] = 1'b0;
            field {
                desc = "Compare each packet's session with SESSION_0..2; a different one makes the packet SESSION.";
                sw = rw; hw = r;
            } session_check[1:1] = 1'b0;
            field {
                desc = "What FEED_COMMIT.resync does: 1 = learn (out of sync until the next accepted packet, which then sets the expected sequence number), 0 = set the expected sequence number to RESYNC_SEQ.";
                sw = rw; hw = r;
            } resync_learn[2:2] = 1'b0;
            field {
                desc = "Bit i: eth_ip_udp_rx filter entry i belongs to this feed (the A and B lines in the same mask).";
                sw = rw; hw = r;
            } filter_mask[15:8] = 8'h0;
        } FEED_CTRL @ 0x00;

        reg {
            name = "Session, bytes 0..3";
            field {
                desc = "Session bytes 0..3 in wire order, byte 0 in [31:24] (\"SESSION001\" -> 0x53455353).";
                sw = rw; hw = r;
            } bytes[31:0] = 32'h0;
        } SESSION_0 @ 0x04;

        reg {
            name = "Session, bytes 4..7";
            field {
                desc = "Session bytes 4..7, byte 4 in [31:24] (\"SESSION001\" -> 0x494F4E30).";
                sw = rw; hw = r;
            } bytes[31:0] = 32'h0;
        } SESSION_1 @ 0x08;

        reg {
            name = "Session, bytes 8..9";
            field {
                desc = "Session bytes 8 and 9, byte 8 in [31:24] (\"SESSION001\" -> 0x3031).";
                sw = rw; hw = r;
            } bytes[31:16] = 16'h0;
        } SESSION_2 @ 0x0C;

        reg {
            name = "Resync sequence number, low";
            field {
                desc = "Expected sequence number set by a resync with resync_learn = 0, bits [31:0].";
                sw = rw; hw = r;
            } seq[31:0] = 32'h0;
        } RESYNC_SEQ_LO @ 0x10;

        reg {
            name = "Resync sequence number, high";
            field {
                desc = "Bits [63:32] of the resync sequence number.";
                sw = rw; hw = r;
            } seq[31:0] = 32'h0;
        } RESYNC_SEQ_HI @ 0x14;

        reg {
            name = "Commit";
            field {
                desc = "Write 1: send FEED_CTRL, SESSION_* and RESYNC_SEQ_* to moldudp64_rx (atomic; it takes them at the first beat of each packet). A commit while the previous one is in flight is not lost: the newest shadow is sent when the transfer is free.";
                sw = w; hw = r; singlepulse;
            } commit[0:0] = 1'b0;
            field {
                desc = "Write 1: commit as above and resync the feed with resync_learn and RESYNC_SEQ of that commit. moldudp64_rx applies it between packets, or after the packet in progress. Like a self-clearing command bit, a request stays pending until a transfer carries it: it is never lost, and requests made before that merge into one resync with the newest shadow. FEED_STATUS.commit_busy reads 0 once it is in moldudp64_rx; software that wants two separate resyncs waits for that between them.";
                sw = w; hw = r; singlepulse;
            } resync[1:1] = 1'b0;
        } FEED_COMMIT @ 0x18;

        reg {
            name = "Status";
            field {
                desc = "1 while a commit or resync is pending or in flight. 0: every write before the last FEED_COMMIT is in effect in moldudp64_rx.";
                sw = r; hw = w;
            } commit_busy[0:0];
        } FEED_STATUS @ 0x1C;

        counter64 EXPECTED_SEQ @ 0x20;  // next expected sequence number (snapshot)

        reg {
            name = "Feed state";
            field {
                desc = "In sync (an accepted packet set the expected sequence number), at the last snapshot.";
                sw = r; hw = w;
            } synced[0:0];
            field {
                desc = "End of session seen: set by an accepted end-of-session packet, kept by heartbeats, cleared by an accepted normal packet or a resync; at the last snapshot.";
                sw = r; hw = w;
            } eos[1:1];
        } FEED_STATE @ 0x28;

        counter64 MOLD_OK            @ 0x40;  // packets per status (mold_status_e)
        counter64 MOLD_HEARTBEAT     @ 0x48;
        counter64 MOLD_EOS           @ 0x50;
        counter64 MOLD_DUP           @ 0x58;
        counter64 MOLD_DISABLED      @ 0x60;
        counter64 MOLD_OTHER_FEED    @ 0x68;
        counter64 MOLD_ABORT         @ 0x70;
        counter64 MOLD_RUNT          @ 0x78;
        counter64 MOLD_SESSION       @ 0x80;
        counter64 MOLD_UNSUPPORTED   @ 0x88;
        counter64 MOLD_MALFORMED     @ 0x90;
        counter64 MOLD_MSGS          @ 0x98;  // messages of OK, HEARTBEAT and EOS packets
        counter64 MOLD_DUP_MSGS      @ 0xA0;  // messages below the expected sequence number
        counter64 MOLD_OVERSIZE_MSGS @ 0xA8;  // messages longer than 64 B, skipped
        counter64 MOLD_GAP_EVENTS    @ 0xB0;  // accepted packets with a gap
        counter64 MOLD_GAP_MSGS      @ 0xB8;  // messages skipped by gaps
    } FEED @ 0x0200;

    regfile {
        name = "Statistics";
        desc = "Receive counters (net clock domain, 64 bit, wrap; cleared only by reset). Software reads them through a snapshot: read STATS_SEQ, write STATS_CTRL.snapshot, wait until STATS_SEQ changes, then read. All counters of one snapshot are taken in the same net clock cycle. DROP_<reason> is at 0x0420 + 8 * (reason - 1), reason = rx_reason_e in hft_pkg.sv.";

        reg {
            name = "Statistics control";
            field {
                desc = "Write 1: take a snapshot of all counters. A request while one is in flight is not lost: it is served when the transfer is free.";
                sw = w; hw = r; singlepulse;
            } snapshot[0:0] = 1'b0;
        } STATS_CTRL @ 0x00;

        reg {
            name = "Snapshot sequence";
            field {
                desc = "Incremented (and wraps) each time a snapshot lands in the registers below.";
                sw = r; hw = na; counter;
            } seq[31:0] = 32'h0;
        } STATS_SEQ @ 0x04;

        counter64 RX_PKTS        @ 0x10;  // frames seen (every outcome)
        counter64 RX_BYTES       @ 0x18;  // frame bytes seen (stat_bytes, every outcome)
        counter64 DROP_DISABLED  @ 0x20;
        counter64 DROP_FCS       @ 0x28;
        counter64 DROP_MAC       @ 0x30;
        counter64 DROP_ETHERTYPE @ 0x38;
        counter64 DROP_IP_HDR    @ 0x40;
        counter64 DROP_FRAG      @ 0x48;
        counter64 DROP_PROTO     @ 0x50;
        counter64 DROP_FILTER    @ 0x58;
        counter64 DROP_LEN       @ 0x60;
    } STATS @ 0x0400;
};
