// HFT CSR map: the single source of the host register interface (SystemRDL 2.0).
// Generated from this file (just gen, checked by just gen-check), never edited by hand:
//   firmware/rtl/core/gen/hft_csr.sv, hft_csr_pkg.sv  (PeakRDL-regblock, AXI4-Lite)
//   software/include/gen/hft_csr.h                    (PeakRDL-cheader)
//   firmware/rdl/hft_csr.md                           (PeakRDL-markdown)
// Blocks are regfiles (a nested addrmap would be an external block in regblock).
// Only blocks with a user in RTL are defined; the other ranges of the 64 KiB window are
// reserved for their phases and answer SLVERR.

addrmap hft_csr {
    name = "HFT FeedHandler CSR";
    desc = "Host register map. 32-bit registers, 64 KiB window, SLVERR on unmapped addresses and illegal accesses.";
    default regwidth = 32;
    default accesswidth = 32;

    regfile {
        name = "Global";
        desc = "Identification and a scratch register.";

        reg {
            name = "Identification";
            field {
                desc = "Constant \"HFT1\" (0x48465431): the right device is mapped.";
                sw = r; hw = na;
            } id[31:0] = 32'h4846_5431;
        } ID @ 0x0;

        reg {
            name = "Register map version";
            field {
                desc = "Major.minor of this map: 0x0005_0004 is the F5 map with the F3 FEED block, the F4 ITCH block and SYMBOL bitmap, the F6 RING block and the F7 RISK, STRATEGY and TX blocks and LOCATE_ALLOW bitmap. A minor step only adds registers (software for an older minor still works); a major step changes existing ones. Software checks it before use.";
                sw = r; hw = na;
            } version[31:0] = 32'h0005_0004;
        } VERSION @ 0x4;

        reg {
            name = "Scratch";
            field {
                desc = "Read/write, no hardware effect: bus read-back test.";
                sw = rw; hw = na;
            } value[31:0] = 32'h0;
        } SCRATCH @ 0x8;
    } GLOBAL @ 0x0000;

    regfile {
        name = "Network receive";
        desc = "eth_ip_udp_rx configuration. Every register here is a shadow: a write changes nothing in the receiver until NET_COMMIT, which moves the whole block to the net clock domain in one transfer; the receiver then switches to it in a single cycle. Reads return the shadow (what was written); NET_STATUS.commit_busy tells whether the last commit has been applied.";

        reg {
            name = "Receive control";
            field {
                desc = "Receiver enabled. 0 after reset: frames are dropped (reason DISABLED) until software has written a complete configuration and committed it with rx_en = 1.";
                sw = rw; hw = r;
            } rx_en[0:0] = 1'b0;
            field {
                desc = "Accept frames to the broadcast MAC ff:ff:ff:ff:ff:ff.";
                sw = rw; hw = r;
            } accept_bcast[1:1] = 1'b0;
        } NET_CTRL @ 0x00;

        reg {
            name = "Local MAC, low";
            field {
                desc = "MAC address bits [31:0]: the last four bytes (02:00:00:00:00:01 -> 0x00000001).";
                sw = rw; hw = r;
            } mac[31:0] = 32'h0;
        } LOCAL_MAC_LO @ 0x04;

        reg {
            name = "Local MAC, high";
            field {
                desc = "MAC address bits [47:32]: the first two bytes (02:00:00:00:00:01 -> 0x0200).";
                sw = rw; hw = r;
            } mac[15:0] = 16'h0;
        } LOCAL_MAC_HI @ 0x08;

        reg {
            name = "Commit";
            field {
                desc = "Write 1: send the whole NET block to the receiver (atomic). A commit while the previous one is in flight is not lost: the newest shadow is sent when the transfer is free.";
                sw = w; hw = r; singlepulse;
            } commit[0:0] = 1'b0;
        } NET_COMMIT @ 0x0C;

        reg {
            name = "Status";
            field {
                desc = "1 while a commit is pending or in flight. 0: every write before the last NET_COMMIT is in effect in the receiver.";
                sw = r; hw = w;
            } commit_busy[0:0];
        } NET_STATUS @ 0x10;

        regfile {
            name = "Destination filter";
            desc = "A frame passes when its destination IP and UDP port equal an enabled entry. The lowest matching index is reported with the payload.";
            reg {
                name = "Filter IP";
                field {
                    desc = "Destination IPv4 address (10.0.0.2 -> 0x0A000002), unicast or multicast group.";
                    sw = rw; hw = r;
                } ip[31:0] = 32'h0;
            } IP @ 0x0;
            reg {
                name = "Filter port and enable";
                field {
                    desc = "Destination UDP port.";
                    sw = rw; hw = r;
                } port[15:0] = 16'h0;
                field {
                    desc = "Entry enabled.";
                    sw = rw; hw = r;
                } en[16:16] = 1'b0;
            } PORT_EN @ 0x4;
        } FILTER[8] @ 0x20 += 0x8;
    } NET @ 0x0100;

    // 64-bit counter read as two words. Values change only when a snapshot lands, so LO and
    // HI of one snapshot always belong together.
    regfile counter64 {
        name = "64-bit counter";
        reg {
            name = "Low word";
            field {
                desc = "Counter bits [31:0] at the last snapshot.";
                sw = r; hw = w;
            } value[31:0];
        } LO @ 0x0;
        reg {
            name = "High word";
            field {
                desc = "Counter bits [63:32] at the last snapshot.";
                sw = r; hw = w;
            } value[31:0];
        } HI @ 0x4;
    };

    regfile {
        name = "MoldUDP64 feed";
        desc = "moldudp64_rx configuration, resync and counters. FEED_CTRL, SESSION_* and RESYNC_SEQ_* are a shadow like the NET block: FEED_COMMIT moves them to the net clock domain in one transfer. EXPECTED_SEQ, FEED_STATE and the MOLD_* counters (net clock domain, 64 bit, wrap; cleared only by reset) are updated by STATS_CTRL.snapshot in the same net clock cycle as the STATS counters; STATS_SEQ counts both. MOLD_<status> is at 0x0240 + 8 * status, status = mold_status_e in hft_pkg.sv. Each FEED_COMMIT write with commit or resync set adds 1 to an 8-bit wrapping count, 0 after reset. It travels with the configuration, so every ring entry carries, as cfg_epoch, the count of the commit in effect at its packet's first beat. The host keeps its own count to match them: every such write counts, also two in consecutive bus cycles, and a write that leaves byte 0 disabled does not.";

        reg {
            name = "Feed control";
            field {
                desc = "Feed enabled. 0 after reset: every packet is counted as DISABLED until software has committed a configuration with enable = 1.";
                sw = rw; hw = r;
            } enable[0:0] = 1'b0;
            field {
                desc = "Compare each packet's session with SESSION_0..2; a different one makes the packet SESSION.";
                sw = rw; hw = r;
            } session_check[1:1] = 1'b0;
            field {
                desc = "What FEED_COMMIT.resync does: 1 = learn (out of sync until the next accepted packet, which then sets the expected sequence number), 0 = set the expected sequence number to RESYNC_SEQ.";
                sw = rw; hw = r;
            } resync_learn[2:2] = 1'b0;
            field {
                desc = "Bit i: eth_ip_udp_rx filter entry i belongs to this feed (the A and B lines in the same mask).";
                sw = rw; hw = r;
            } filter_mask[15:8] = 8'h0;
        } FEED_CTRL @ 0x00;

        reg {
            name = "Session, bytes 0..3";
            field {
                desc = "Session bytes 0..3 in wire order, byte 0 in [31:24] (\"SESSION001\" -> 0x53455353).";
                sw = rw; hw = r;
            } bytes[31:0] = 32'h0;
        } SESSION_0 @ 0x04;

        reg {
            name = "Session, bytes 4..7";
            field {
                desc = "Session bytes 4..7, byte 4 in [31:24] (\"SESSION001\" -> 0x494F4E30).";
                sw = rw; hw = r;
            } bytes[31:0] = 32'h0;
        } SESSION_1 @ 0x08;

        reg {
            name = "Session, bytes 8..9";
            field {
                desc = "Session bytes 8 and 9, byte 8 in [31:24] (\"SESSION001\" -> 0x3031).";
                sw = rw; hw = r;
            } bytes[31:16] = 16'h0;
        } SESSION_2 @ 0x0C;

        reg {
            name = "Resync sequence number, low";
            field {
                desc = "Expected sequence number set by a resync with resync_learn = 0, bits [31:0].";
                sw = rw; hw = r;
            } seq[31:0] = 32'h0;
        } RESYNC_SEQ_LO @ 0x10;

        reg {
            name = "Resync sequence number, high";
            field {
                desc = "Bits [63:32] of the resync sequence number.";
                sw = rw; hw = r;
            } seq[31:0] = 32'h0;
        } RESYNC_SEQ_HI @ 0x14;

        reg {
            name = "Commit";
            field {
                desc = "Write 1: send FEED_CTRL, SESSION_* and RESYNC_SEQ_* to moldudp64_rx (atomic; it takes them at the first beat of each packet). A commit while the previous one is in flight is not lost: the newest shadow is sent when the transfer is free.";
                sw = w; hw = r; singlepulse; swmod;
            } commit[0:0] = 1'b0;
            field {
                desc = "Write 1: commit as above and resync the feed with resync_learn and RESYNC_SEQ of that commit. moldudp64_rx applies it between packets, or after the packet in progress. Like a self-clearing command bit, a request stays pending until a transfer carries it: it is never lost, and requests made before that merge into one resync with the newest shadow. FEED_STATUS.commit_busy reads 0 once it is in moldudp64_rx; software that wants two separate resyncs waits for that between them.";
                sw = w; hw = r; singlepulse;
            } resync[1:1] = 1'b0;
        } FEED_COMMIT @ 0x18;

        reg {
            name = "Status";
            field {
                desc = "1 while a commit or resync is pending or in flight. 0: every write before the last FEED_COMMIT is in effect in moldudp64_rx.";
                sw = r; hw = w;
            } commit_busy[0:0];
        } FEED_STATUS @ 0x1C;

        counter64 EXPECTED_SEQ @ 0x20;  // next expected sequence number (snapshot)

        reg {
            name = "Feed state";
            field {
                desc = "In sync (an accepted packet set the expected sequence number), at the last snapshot.";
                sw = r; hw = w;
            } synced[0:0];
            field {
                desc = "End of session seen: set by an accepted end-of-session packet, kept by heartbeats, cleared by an accepted normal packet or a resync; at the last snapshot.";
                sw = r; hw = w;
            } eos[1:1];
        } FEED_STATE @ 0x28;

        counter64 MOLD_OK            @ 0x40;  // packets per status (mold_status_e)
        counter64 MOLD_HEARTBEAT     @ 0x48;
        counter64 MOLD_EOS           @ 0x50;
        counter64 MOLD_DUP           @ 0x58;
        counter64 MOLD_DISABLED      @ 0x60;
        counter64 MOLD_OTHER_FEED    @ 0x68;
        counter64 MOLD_ABORT         @ 0x70;
        counter64 MOLD_RUNT          @ 0x78;
        counter64 MOLD_SESSION       @ 0x80;
        counter64 MOLD_UNSUPPORTED   @ 0x88;
        counter64 MOLD_MALFORMED     @ 0x90;
        counter64 MOLD_MSGS          @ 0x98;  // messages of OK, HEARTBEAT and EOS packets
        counter64 MOLD_DUP_MSGS      @ 0xA0;  // messages below the expected sequence number
        counter64 MOLD_OVERSIZE_MSGS @ 0xA8;  // messages longer than 64 B, skipped
        counter64 MOLD_GAP_EVENTS    @ 0xB0;  // accepted packets with a gap
        counter64 MOLD_GAP_MSGS      @ 0xB8;  // messages skipped by gaps
    } FEED @ 0x0200;

    // A 64-bit counter of the host clock domain: live, so LO and HI of one value need a retry.
    regfile counter64_live {
        name = "64-bit live counter";
        reg {
            name = "Low word";
            field {
                desc = "Counter bits [31:0], live. To read the pair: read HI, LO, HI again, and repeat if the two HI differ.";
                sw = r; hw = w;
            } value[31:0];
        } LO @ 0x0;
        reg {
            name = "High word";
            field {
                desc = "Counter bits [63:32], live.";
                sw = r; hw = w;
            } value[31:0];
        } HI @ 0x4;
    };

    regfile {
        name = "Host event ring";
        desc = "event_ring_writer configuration and state, in the host clock domain (no commit, no snapshot, except the net counters below). Host obligations: the region is 2^RING_SIZE_LOG2 entries of 128 B, aligned to 4 KiB; before EVERY enable the host fills it with zeros and writes CONS_IDX = 0. The hardware checks only CONS_IDX and the size, on the rising edge of RING_CTRL.enable: otherwise the enable is refused (RING_STATUS.enable_err) and the writer stays stopped. It cannot detect a region left dirty, or a CONS_IDX that passes the entries written. The host reads each 64 B line's ctrl byte with acquire and only then the fields, checks that both lines' phase match, and writes CONS_IDX from time to time (posted, for example every N/4 entries). Identities: at every snapshot RING_COMMIT_ENTRIES + RING_DROP_ENTRIES + RING_DROP_ORDERS + RING_ORDER_QUEUED = ITCH_OUT + MOLD_GAP_EVENTS + MOLD_EOS + ORDERS_SENT_HW + ORDERS_SENT_HOST + the sum of RISK_REJECT_<reason>; with the ring path idle RING_COMMIT_ENTRIES = RING_WRITTEN + RING_BRESP_ERR.";

        reg {
            name = "Ring control";
            field {
                desc = "Writer enabled. A rising edge with CONS_IDX = 0 and RING_SIZE_LOG2 in 4..20 sets PROD_IDX to 0, takes RING_BASE_* and RING_SIZE_LOG2 (ignored until the next rising edge) and clears RING_STATUS; any other rising edge is refused. To retry after a refusal: write 0, then 1. Falling edge: bursts in flight finish, no new entry starts.";
                sw = rw; hw = r;
            } enable[0:0] = 1'b0;
        } RING_CTRL @ 0x00;

        reg {
            name = "Ring base address, low";
            field {
                desc = "Base address bits [31:12]; the region is 4 KiB aligned and bits [11:0] read 0.";
                sw = rw; hw = r;
            } base[31:12] = 20'h0;
        } RING_BASE_LO @ 0x04;

        reg {
            name = "Ring base address, high";
            field {
                desc = "Base address bits [63:32].";
                sw = rw; hw = r;
            } base[31:0] = 32'h0;
        } RING_BASE_HI @ 0x08;

        reg {
            name = "Ring size";
            field {
                desc = "log2 of the number of entries, 4..20. Any other value makes the next enable refused.";
                sw = rw; hw = r;
            } size_log2[4:0] = 5'h0;
        } RING_SIZE_LOG2 @ 0x0C;

        reg {
            name = "Consumer index";
            field {
                desc = "Entries the host has consumed: a wrapping 32-bit count, the same arithmetic as PROD_IDX. PROD_IDX - CONS_IDX = 2^RING_SIZE_LOG2 means full, and the writer waits. It must be 0 at each enable and must never pass PROD_IDX.";
                sw = rw; hw = r;
            } cons[31:0] = 32'h0;
        } CONS_IDX @ 0x10;

        reg {
            name = "Producer index";
            field {
                desc = "Bursts started since the last accepted enable, live, wrapping. An entry counted here may still be on its way: the phase bits tell which entries are in memory.";
                sw = r; hw = w;
            } prod[31:0];
        } PROD_IDX @ 0x14;

        reg {
            name = "Ring status";
            field {
                desc = "A write answered with a BRESP other than OKAY since the last accepted enable. The write is not retried; RING_BRESP_ERR counts them.";
                sw = r; hw = w;
            } bresp_err[0:0];
            field {
                desc = "The last rising edge of RING_CTRL.enable was refused: CONS_IDX was not 0 or RING_SIZE_LOG2 was not in 4..20. Stays set until an accepted enable.";
                sw = r; hw = w;
            } enable_err[1:1];
        } RING_STATUS @ 0x18;

        counter64_live RING_WRITTEN   @ 0x20;  // entries answered with OKAY
        counter64_live RING_BRESP_ERR @ 0x28;  // entries answered with another BRESP

        // Net clock domain, updated by STATS_CTRL.snapshot with the STATS, MOLD_* and ITCH_* counters.
        counter64 RING_COMMIT_ENTRIES @ 0x40;  // entries committed to the FIFO, GAP and EOS included
        counter64 RING_DROP_PKTS      @ 0x48;  // accepted packets that did not fit the FIFO
        counter64 RING_DROP_ENTRIES   @ 0x50;  // their entries, GAP and EOS included
        counter64 RING_DROP_ORDERS    @ 0x58;  // decision RISK_REJECT entries with no ring credit, not written

        reg {
            name = "Order entries queued";
            field {
                desc = "ORDER_SENT and RISK_REJECT entries counted by ORDERS_SENT_* and RISK_REJECT_* and waiting in event_packer's order queue (0..16), at the last snapshot. It keeps the identity above in every snapshot.";
                sw = r; hw = w;
            } queued[4:0];
        } RING_ORDER_QUEUED @ 0x60;
    } RING @ 0x0800;

    regfile {
        name = "Statistics";
        desc = "Receive counters (net clock domain, 64 bit, wrap; cleared only by reset). Software reads them through a snapshot: read STATS_SEQ, write STATS_CTRL.snapshot, wait until STATS_SEQ changes, then read. All counters of one snapshot are taken in the same net clock cycle. DROP_<reason> is at 0x0420 + 8 * (reason - 1), reason = rx_reason_e in hft_pkg.sv.";

        reg {
            name = "Statistics control";
            field {
                desc = "Write 1: take a snapshot of all counters. A request while one is in flight is not lost: it is served when the transfer is free.";
                sw = w; hw = r; singlepulse;
            } snapshot[0:0] = 1'b0;
        } STATS_CTRL @ 0x00;

        reg {
            name = "Snapshot sequence";
            field {
                desc = "Incremented (and wraps) each time a snapshot lands in the registers below.";
                sw = r; hw = na; counter;
            } seq[31:0] = 32'h0;
        } STATS_SEQ @ 0x04;

        counter64 RX_PKTS        @ 0x10;  // frames seen (every outcome)
        counter64 RX_BYTES       @ 0x18;  // frame bytes seen (stat_bytes, every outcome)
        counter64 DROP_DISABLED  @ 0x20;
        counter64 DROP_FCS       @ 0x28;
        counter64 DROP_MAC       @ 0x30;
        counter64 DROP_ETHERTYPE @ 0x38;
        counter64 DROP_IP_HDR    @ 0x40;
        counter64 DROP_FRAG      @ 0x48;
        counter64 DROP_PROTO     @ 0x50;
        counter64 DROP_FILTER    @ 0x58;
        counter64 DROP_LEN       @ 0x60;
    } STATS @ 0x0400;

    regfile {
        name = "ITCH 5.0 decoder";
        desc = "itch_decoder configuration and counters. ITCH_CTRL is a shadow that FEED_COMMIT carries with the FEED block (one atomic commit; moldudp64_rx takes it at the first beat of each packet and the decoder applies it to every message of that packet). The ITCH_* counters (net clock domain, 64 bit, wrap; cleared only by reset) count committed messages only: those of OK, HEARTBEAT and EOS packets, like MOLD_MSGS. They are updated by STATS_CTRL.snapshot in the same net clock cycle as the STATS and MOLD_* counters. ITCH_<class> is at 0x0640 + 8 * class, class = itch_class_e in hft_pkg.sv. Between two snapshots: the sum of ITCH_<class> moves by MOLD_MSGS, and ITCH_OUT + ITCH_FILTERED + ITCH_MASKED by the sum of ITCH_<class>.";

        reg {
            name = "ITCH control";
            field {
                desc = "Bit c: messages of class c (itch_class_e) are output; 0 = counted as MASKED. 0 after reset: no message is output until software has committed a configuration.";
                sw = rw; hw = r;
            } class_en[5:0] = 6'h0;
            field {
                desc = "Bit c: messages of class c go through the SYMBOL bitmap; a message whose stock locate is not 0 and whose bitmap bit is 0 is counted as FILTERED. Locate 0 (market-wide messages) and messages shorter than the 11-byte header always pass.";
                sw = rw; hw = r;
            } class_filter[13:8] = 6'h0;
        } ITCH_CTRL @ 0x00;

        counter64 ITCH_ORDER     @ 0x40;  // messages per class (itch_class_e)
        counter64 ITCH_TRADE     @ 0x48;
        counter64 ITCH_ADMIN     @ 0x50;
        counter64 ITCH_AUCTION   @ 0x58;
        counter64 ITCH_UNKNOWN   @ 0x60;
        counter64 ITCH_MALFORMED @ 0x68;
        counter64 ITCH_OUT       @ 0x70;  // messages output
        counter64 ITCH_FILTERED  @ 0x78;  // dropped by the SYMBOL bitmap
        counter64 ITCH_MASKED    @ 0x80;  // dropped by ITCH_CTRL.class_en
    } ITCH @ 0x0600;

    regfile {
        name = "Pre-trade risk";
        desc = "risk_check limits, kill switch, order budget and counters. MAX_QTY .. RATE_BURST are a shadow that RISK_COMMIT moves to the net clock domain in one piece. RISK_COMMIT and BUDGET_ADD are commands: they go to the net clock domain in bus order with the STRATEGY and TX commands, after every MBOX_SEND written before them has been decided and after RISK_CTRL and TX_CTRL written before them are in effect, and their write response comes once they are in effect. While one is in flight every other register access waits. The counters (net clock domain, 64 bit, wrap; cleared only by reset) and BUDGET are updated by STATS_CTRL.snapshot in the same net clock cycle as the other snapshot counters. RISK_REJECT_<reason> is at 0x0A60 + 8 * (reason - 1), reason = risk_reason_e in hft_pkg.sv; it counts the rejects not written to the ring too (RING_DROP_ORDERS).";

        reg {
            name = "Maximum quantity";
            field {
                desc = "An order with qty > max_qty is rejected (QTY). 0 after reset.";
                sw = rw; hw = r;
            } max_qty[31:0] = 32'h0;
        } MAX_QTY @ 0x00;

        reg {
            name = "Maximum notional, low";
            field {
                desc = "Bits [31:0] of the maximum qty * price (price in ITCH Price(4) units). An order above it is rejected (NOTIONAL).";
                sw = rw; hw = r;
            } value[31:0] = 32'h0;
        } MAX_NOTIONAL_LO @ 0x04;

        reg {
            name = "Maximum notional, high";
            field {
                desc = "Bits [63:32] of the maximum notional.";
                sw = rw; hw = r;
            } value[31:0] = 32'h0;
        } MAX_NOTIONAL_HI @ 0x08;

        reg {
            name = "Token refill";
            field {
                desc = "Tokens added every RATE_PERIOD net clock cycles, up to RATE_BURST.";
                sw = rw; hw = r;
            } refill[31:0] = 32'h0;
        } RATE_REFILL @ 0x0C;

        reg {
            name = "Token period";
            field {
                desc = "Net clock cycles between refills; 0 = no refill (the bucket only empties).";
                sw = rw; hw = r;
            } period[31:0] = 32'h0;
        } RATE_PERIOD @ 0x10;

        reg {
            name = "Token bucket size";
            field {
                desc = "Bucket size. Each RISK_COMMIT fills the bucket to it and restarts the period. An accepted order takes one token; with none it is rejected (RATE).";
                sw = rw; hw = r;
            } burst[31:0] = 32'h0;
        } RATE_BURST @ 0x14;

        external reg {
            name = "Risk commit";
            field {
                desc = "Write 1: command that sends MAX_QTY .. RATE_BURST to risk_check in one piece; the write response comes once it is in effect. A write with 0 does nothing.";
                sw = w; hw = r;
            } commit[0:0];
        } RISK_COMMIT @ 0x18;

        reg {
            name = "Risk control";
            field {
                desc = "Kill switch, 1 after reset. Not a shadow: it reaches the net clock domain through a synchronizer, without a commit. While 1 every order is rejected (KILL); its rise cancels the TX queue and disarms every rule. Software releases it last, after the whole configuration (software contract after reset).";
                sw = rw; hw = r;
            } kill[0:0] = 1'b1;
        } RISK_CTRL @ 0x1C;

        external reg {
            name = "Add to the budget";
            field {
                desc = "Command: adds the written value to the order budget (saturating at 2^32 - 1); the write response comes once it is in effect. Each accepted order uses one unit; with 0 an order is rejected (BUDGET). The budget is 0 after reset.";
                sw = w; hw = r;
            } amount[31:0];
        } BUDGET_ADD @ 0x20;

        reg {
            name = "Budget";
            field {
                desc = "Order budget left, at the last snapshot.";
                sw = r; hw = w;
            } budget[31:0];
        } BUDGET @ 0x24;

        counter64 ORDERS_SENT_HW     @ 0x40;  // ORDER_SENT entries of rule orders
        counter64 ORDERS_SENT_HOST   @ 0x48;  // ORDER_SENT entries of mailbox orders
        counter64 RISK_REJECT_KILL      @ 0x60;  // RISK_REJECT per reason (risk_reason_e)
        counter64 RISK_REJECT_TX_OFF    @ 0x68;
        counter64 RISK_REJECT_INVALID   @ 0x70;
        counter64 RISK_REJECT_LOCATE    @ 0x78;
        counter64 RISK_REJECT_QTY       @ 0x80;
        counter64 RISK_REJECT_NOTIONAL  @ 0x88;
        counter64 RISK_REJECT_BUDGET    @ 0x90;
        counter64 RISK_REJECT_RATE      @ 0x98;
        counter64 RISK_REJECT_TX_BUSY   @ 0xA0;
        counter64 RISK_REJECT_RING_FULL @ 0xA8;
    } RISK @ 0x0A00;

    regfile {
        name = "Strategy rules";
        desc = "strategy_engine's 8 rules, written indirectly: RULE_SEL picks a rule, RULE_CTRL .. RULE_OFFSET are one shadow, RULE_COMMIT replaces the selected rule with it in one piece and disarms it. Reads return the shadow, not the rule in effect. RULE_COMMIT, RULE_ARM and RULE_DISARM are commands, in bus order with the RISK and TX commands (see RISK); their write response comes once they are in effect. RULE_ARMED and RULE_FIRED_<n> (net clock domain) are updated by STATS_CTRL.snapshot with the other snapshot counters.";

        reg {
            name = "Rule select";
            field {
                desc = "The rule RULE_COMMIT writes.";
                sw = rw; hw = r;
            } idx[2:0] = 3'h0;
        } RULE_SEL @ 0x00;

        reg {
            name = "Rule control";
            field {
                desc = "Rule enabled.";
                sw = rw; hw = r;
            } enable[0:0] = 1'b0;
            field {
                desc = "Message types that can fire it: bit 0 A, bit 1 F, bit 2 P.";
                sw = rw; hw = r;
            } msg_mask[3:1] = 3'h0;
            field {
                desc = "Event sides that match: bit 0 B, bit 1 S.";
                sw = rw; hw = r;
            } side_match[5:4] = 2'h0;
            field {
                desc = "0: event price <= RULE_THRESHOLD matches, 1: >=.";
                sw = rw; hw = r;
            } price_ge[6:6] = 1'b0;
            field {
                desc = "Order side: 0 buy, 1 sell, 2 the event's opposite; 3 is a static error.";
                sw = rw; hw = r;
            } action_side[9:8] = 2'h0;
            field {
                desc = "0: the order quantity is RULE_QTY; 1: min(event shares, RULE_QTY).";
                sw = rw; hw = r;
            } qty_min[10:10] = 1'b0;
            field {
                desc = "0: the order price is the event price; 1: RULE_THRESHOLD + RULE_OFFSET.";
                sw = rw; hw = r;
            } price_threshold_mode[11:11] = 1'b0;
            field {
                desc = "OUCH Time In Force code of the order (0, 3, 5 or E; any other is a static error).";
                sw = rw; hw = r;
            } tif[23:16] = 8'h0;
        } RULE_CTRL @ 0x04;

        reg {
            name = "Rule locate";
            field {
                desc = "Stock locate the rule watches; 0 is a static error. The rule sees only the messages itch_decoder outputs: its locate needs the ORDER or TRADE class enabled in ITCH_CTRL and, if that class is filtered, its SYMBOL bit set, else the rule never fires.";
                sw = rw; hw = r;
            } locate[15:0] = 16'h0;
        } RULE_LOCATE @ 0x08;

        reg {
            name = "Rule price threshold";
            field {
                desc = "Price threshold, ITCH Price(4).";
                sw = rw; hw = r;
            } threshold[31:0] = 32'h0;
        } RULE_THRESHOLD @ 0x0C;

        reg {
            name = "Rule minimum shares";
            field {
                desc = "An event matches only with shares >= this.";
                sw = rw; hw = r;
            } min_shares[31:0] = 32'h0;
        } RULE_MIN_SHARES @ 0x10;

        reg {
            name = "Rule quantity";
            field {
                desc = "Order quantity, or its maximum with qty_min = 1.";
                sw = rw; hw = r;
            } qty[31:0] = 32'h0;
        } RULE_QTY @ 0x14;

        reg {
            name = "Rule price offset";
            field {
                desc = "Signed offset added to RULE_THRESHOLD with price_threshold_mode = 1.";
                sw = rw; hw = r;
            } offset[31:0] = 32'h0;
        } RULE_OFFSET @ 0x18;

        external reg {
            name = "Rule commit";
            field {
                desc = "Write 1: command that replaces rule RULE_SEL with the shadow and disarms it; the write response comes once it is in effect, and RULE_STATUS then shows its static error. A write with 0 does nothing.";
                sw = w; hw = r;
            } commit[0:0];
        } RULE_COMMIT @ 0x1C;

        external reg {
            name = "Arm rules";
            field {
                desc = "Command: arms the rules whose bit is 1; the write response comes once it is in effect.";
                sw = w; hw = r;
            } mask[7:0];
        } RULE_ARM @ 0x20;

        external reg {
            name = "Disarm rules";
            field {
                desc = "Command: disarms the rules whose bit is 1; the write response comes once it is in effect.";
                sw = w; hw = r;
            } mask[7:0];
        } RULE_DISARM @ 0x24;

        reg {
            name = "Rule status";
            field {
                desc = "Bit n: rule n has a static error and never fires (locate 0, a TIF the core does not send, action_side 3, quantity 0 or >= 1,000,000, threshold + offset outside the exchange's price range). As of the last command's response; 0xFF after reset (every rule is cleared).";
                sw = r; hw = w;
            } error[7:0];
        } RULE_STATUS @ 0x28;

        reg {
            name = "Armed rules";
            field {
                desc = "Bit n: rule n armed, at the last snapshot.";
                sw = r; hw = w;
            } armed[7:0];
        } RULE_ARMED @ 0x2C;

        counter64 RULE_FIRED_0 @ 0x40;  // orders of rule n released by their accepted packet
        counter64 RULE_FIRED_1 @ 0x48;
        counter64 RULE_FIRED_2 @ 0x50;
        counter64 RULE_FIRED_3 @ 0x58;
        counter64 RULE_FIRED_4 @ 0x60;
        counter64 RULE_FIRED_5 @ 0x68;
        counter64 RULE_FIRED_6 @ 0x70;
        counter64 RULE_FIRED_7 @ 0x78;
    } STRATEGY @ 0x1000;

    regfile {
        name = "Order transmit and mailbox";
        desc = "order_tx_builder configuration, the UserRefNum counter and the host order mailbox. TX_OUCH and TX_TEMPLATE_* are a shadow that TX_COMMIT sends in one piece; TX_COMMIT and TX_USERREF_NEXT are commands in bus order with the RISK and STRATEGY commands (see RISK). MBOX_* fields are a shadow that MBOX_SEND copies into a 16-entry FIFO to the net clock domain (posted).";

        reg {
            name = "Transmit control";
            field {
                desc = "Order transmit enabled, 0 after reset. Not a shadow: it reaches the net clock domain through a synchronizer. In effect only after an accepted TX_COMMIT. While 0 every order is rejected (TX_OFF); its fall cancels the TX queue.";
                sw = rw; hw = r;
            } tx_en[0:0] = 1'b0;
        } TX_CTRL @ 0x00;

        reg {
            name = "OUCH constants";
            field {
                desc = "Display: Y, N or A.";
                sw = rw; hw = r;
            } display[7:0] = 8'h0;
            field {
                desc = "Capacity: A, P, R or O.";
                sw = rw; hw = r;
            } capacity[15:8] = 8'h0;
            field {
                desc = "Intermarket Sweep Eligibility: N only.";
                sw = rw; hw = r;
            } ise[23:16] = 8'h0;
            field {
                desc = "CrossType: N only.";
                sw = rw; hw = r;
            } cross_type[31:24] = 8'h0;
        } TX_OUCH @ 0x04;

        external reg {
            name = "Transmit commit";
            field {
                desc = "Write 1: command that sends TX_OUCH and TX_TEMPLATE_* to order_tx_builder; the write response comes once it is decided. Accepted only while the order path is closed (RISK_CTRL.kill = 1 or TX_CTRL.tx_en = 0) and the values are valid (OUCH constants as above; template: EtherType 0x0800, 0x45, total length 78, flags/fragment 0x4000, protocol 17, a correct IPv4 header checksum, UDP length 58, UDP checksum 0); else refused and the previous configuration stays. TX_STATUS shows the outcome. A write with 0 does nothing.";
                sw = w; hw = r;
            } commit[0:0];
        } TX_COMMIT @ 0x08;

        reg {
            name = "Transmit status";
            field {
                desc = "A TX_COMMIT has been accepted since reset (needed for transmit).";
                sw = r; hw = w;
            } cfg_valid[0:0];
            field {
                desc = "The last TX_COMMIT was refused. Cleared by an accepted one; 0 after reset.";
                sw = r; hw = w;
            } cfg_refused[1:1];
            field {
                desc = "The last TX_USERREF_NEXT write was ignored (kill not 1, orders still queued, or 0). Cleared by one that takes effect; 0 after reset.";
                sw = r; hw = w;
            } userref_ignored[2:2];
        } TX_STATUS @ 0x0C;

        external reg {
            name = "Set the next UserRefNum";
            field {
                desc = "Command: sets the UserRefNum the next order takes; the write response comes once it is decided. It takes effect only while RISK_CTRL.kill = 1, no order is queued and the value is not 0, else TX_STATUS.userref_ignored. Software writes it before releasing kill (software contract after reset).";
                sw = w; hw = r;
            } value[31:0];
        } TX_USERREF_NEXT @ 0x10;

        external reg {
            name = "Next UserRefNum";
            field {
                desc = "The UserRefNum the next order takes, live (read through the command channel, in bus order); 1 after reset, 0 once none is left (2^32).";
                sw = r; hw = w;
            } value[31:0];
        } TX_USERREF @ 0x14;

        reg {
            name = "Frame template";
            field {
                desc = "Template bytes 4i .. 4i+3 of the 42-byte Ethernet/IPv4/UDP header, byte 4i in [31:24] (wire order).";
                sw = rw; hw = r;
            } bytes[31:0] = 32'h0;
        } TX_TEMPLATE[10] @ 0x20 += 0x4;

        reg {
            name = "Frame template, last bytes";
            field {
                desc = "Template bytes 40 and 41, byte 40 in [31:24].";
                sw = rw; hw = r;
            } bytes[31:16] = 16'h0;
        } TX_TEMPLATE_TAIL @ 0x48;

        reg {
            name = "Mailbox side";
            field {
                desc = "OUCH Side: B or S (any other is rejected INVALID).";
                sw = rw; hw = r;
            } side[7:0] = 8'h0;
        } MBOX_SIDE @ 0x50;

        reg {
            name = "Mailbox quantity";
            field {
                desc = "Order quantity.";
                sw = rw; hw = r;
            } qty[31:0] = 32'h0;
        } MBOX_QTY @ 0x54;

        reg {
            name = "Mailbox price";
            field {
                desc = "Limit price, ITCH Price(4).";
                sw = rw; hw = r;
            } price[31:0] = 32'h0;
        } MBOX_PRICE @ 0x58;

        reg {
            name = "Mailbox locate";
            field {
                desc = "Stock locate (for LOCATE_ALLOW and the ring entry; matching it with MBOX_STOCK_* is the host's rule).";
                sw = rw; hw = r;
            } locate[15:0] = 16'h0;
        } MBOX_LOCATE @ 0x5C;

        reg {
            name = "Mailbox stock, bytes 0..3";
            field {
                desc = "Symbol bytes 0..3 in wire order, byte 0 in [31:24] (space padded, as ITCH Stock).";
                sw = rw; hw = r;
            } bytes[31:0] = 32'h0;
        } MBOX_STOCK_0 @ 0x60;

        reg {
            name = "Mailbox stock, bytes 4..7";
            field {
                desc = "Symbol bytes 4..7, byte 4 in [31:24].";
                sw = rw; hw = r;
            } bytes[31:0] = 32'h0;
        } MBOX_STOCK_1 @ 0x64;

        reg {
            name = "Mailbox time in force";
            field {
                desc = "OUCH Time In Force code.";
                sw = rw; hw = r;
            } tif[7:0] = 8'h0;
        } MBOX_TIF @ 0x68;

        reg {
            name = "Mailbox ClOrdID";
            field {
                desc = "ClOrdID bytes 4i .. 4i+3, byte 4i in [31:24]; every byte in [0-9A-Za-z ] (else INVALID).";
                sw = rw; hw = r;
            } bytes[31:0] = 32'h0;
        } MBOX_CLORDID[3] @ 0x70 += 0x4;

        reg {
            name = "Mailbox ClOrdID, last bytes";
            field {
                desc = "ClOrdID bytes 12 and 13, byte 12 in [31:24].";
                sw = rw; hw = r;
            } bytes[31:16] = 16'h0;
        } MBOX_CLORDID_TAIL @ 0x7C;

        reg {
            name = "Mailbox send";
            field {
                desc = "Write 1: copy MBOX_SIDE .. MBOX_CLORDID_TAIL into the mailbox FIFO (posted). With the FIFO full it is dropped: MBOX_STATUS.dropped and MBOX_DROP. Each such write sends once, also two in consecutive bus cycles.";
                sw = w; hw = r; singlepulse; swmod;
            } send[0:0] = 1'b0;
        } MBOX_SEND @ 0x80;

        reg {
            name = "Mailbox space";
            field {
                desc = "Free FIFO entries, live (0 during reset): this many MBOX_SEND writes from now on all fit.";
                sw = r; hw = w;
            } space[4:0];
        } MBOX_SPACE @ 0x84;

        reg {
            name = "Mailbox status";
            field {
                desc = "The last MBOX_SEND was dropped. Cleared by one that fits; 0 after reset.";
                sw = r; hw = w;
            } dropped[0:0];
        } MBOX_STATUS @ 0x88;

        counter64_live MBOX_DROP @ 0x90;  // MBOX_SEND writes dropped (host clock domain)
    } TX @ 0x2000;

    external mem {
        name = "Symbol bitmap";
        desc = "Stock-locate subscription bitmap of itch_decoder: bit i of word w is stock locate 32 * w + i (1 = subscribed). Written only by software; the hardware never writes it. After a reset the hardware clears every word (2048 net clock cycles, about 13 us); an access in that time waits until the clearing is done, so the bitmap reads 0 after reset. A write's response (BRESP) comes once it is in effect: every message looked up after it sees the new value. Software keeps its own copy and rewrites all 2048 words after every reset (see the software contract after reset).";
        mementries = 2048;
        memwidth = 32;
        sw = rw;
    } SYMBOL @ 0x8000;

    external mem {
        name = "Locate allow bitmap";
        desc = "risk_check's allow bitmap: bit i of word w is stock locate 32 * w + i (1 = orders allowed; 0 = rejected LOCATE). Written only by software. After a reset the hardware clears every word (2048 net clock cycles); an access in that time waits until the clearing is done. An access is in bus order with the RISK, STRATEGY and TX commands, and a write's response comes once it is in effect: every order decided after it sees the new value. Software keeps its own copy and rewrites it after every reset (software contract after reset).";
        mementries = 2048;
        memwidth = 32;
        sw = rw;
    } LOCATE_ALLOW @ 0xA000;
};
